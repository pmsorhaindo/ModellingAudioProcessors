* GENERATED by spice/run_refs.py (koren, main) -- do not edit; change dk/circuit.VALUES or
* run_refs.SOLVER and run `python spice/run_refs.py --write-netlist`. spice/tests/test_netlists.py checks it.
* One-stage 12AX7 common-cathode stage. Component values: dk/circuit.VALUES (example values, NOT Culture
* Vulture values; sources in dk/circuit.py).
* Valve: Norman Koren "12AX7 NEW MODEL" (fetched by models/fetch_models.sh, not redistributed).
* Solver: reltol=1e-06, abstol=1e-14, vntol=1e-09, chgtol=1e-16, method=trap, tstep=5e-07, tmax=5e-07.
* .spiceinit sets ngbehavior=psa.
.include models/12ax7_koren.lib
VHT ht 0 DC 300
Vin src 0 DC 0 AC 1 SIN(0 0.05 1000)
Rs  src in1 1k
Cin in1 gl 22n
Rg  gl 0 1Meg
Rgs gl g 68k
XV1 a g k 12AX7
Ra  ht a 100k
Rk  k 0 1.5k
Ck  k 0 22u
Cout a out 22n
Rl  out 0 1Meg
.options reltol=1e-06 abstol=1e-14 vntol=1e-09 chgtol=1e-16 method=trap

.control
op
let ia = -i(VHT)
wrdata out/koren_op.txt v(a) v(k) v(g) v(gl) ia
ac dec 50 1 100k
wrdata out/koren_ac.txt db(v(out)) ph(v(out))
ac lin 1 20 20
wrdata out/koren_ac_20.txt db(v(out)) ph(v(out))
ac lin 1 20k 20k
wrdata out/koren_ac_20000.txt db(v(out)) ph(v(out))
foreach A 0.05 0.5 2 8
  alter @Vin[sin] = [ 0 $A 1000 ]
  tran 5e-07 0.5 0.3 5e-07
  set fn = out/koren_sine_{$A}.txt
  wrdata $fn v(out) v(g) v(k)
end
.endc
.end
