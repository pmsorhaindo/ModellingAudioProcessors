* One-stage 12AX7 common-cathode reference netlist (ngspice) - LONG sine runs (v2)
* 500 ms per drive level; data saved from 300 ms so Cin/Ck/Cout have settled.
* Harmonics are computed in python (analysis/harmonics.py) over the last 100 cycles.
* Valve model: Norman Koren "12AX7 NEW MODEL" from Koren Tube.lib (see models/README.md)
*   (not redistributed; fetch with models/fetch_models.sh)
*
* COMPONENT VALUES ARE CHOSEN EXAMPLE VALUES, NOT CULTURE VULTURE VALUES.
* From Merlin Blencowe, "Designing Valve Preamps for Guitar and Bass", ch.1
*   (https://www.valvewizard.co.uk/Common_Gain_Stage.pdf):
*   HT = 300 V, Ra = 100k, Rk = 1.5k (sec 1.10 worked example), Rg (grid leak) = 1M (sec 1.9 "typically 1MΩ").
* Chosen by Ohm as conventional round values (NOT from that source):
*   Cin = 22n, Ck = 22u (fully bypassed, f_lo=1/(2*pi*Rk*Ck)≈4.8 Hz), Cout = 22n,
*   Rl (next-stage grid leak) = 1M, source resistance Rs = 1k, grid stopper Rgs = 68k.
.include models/12ax7_koren.lib   ; Koren "12AX7 NEW MODEL", fetched by models/fetch_models.sh (not redistributed)
.param amp=0.1
VHT ht 0 DC 300
Vin src 0 DC 0 AC 1 SIN(0 {amp} 1k)
Rs  src in1 1k
Cin in1 gl 22n
Rg  gl 0 1Meg
Rgs gl g 68k
XV1 a g k 12AX7
Ra  ht a 100k
Rk  k 0 1.5k
Ck  k 0 22u
Cout a out 22n
Rl  out 0 1Meg
.options reltol=1e-4 abstol=1e-12 vntol=1e-7
.control
foreach A 0.05 0.5 2 8
  alter @Vin[sin] = [ 0 $A 1k ]
  tran 2u 500m 300m 2u
  set fn = out/tran_long_{$A}V.txt
  wrdata $fn v(g) v(k) v(a) v(out)
  fourier 1k v(out)
end
.endc
.end
