* GENERATED by spice6as6/run_refs.py (dual, P2, main, bias 0.45 mA) -- do not edit; change
* dk6as6/circuit.VALUES or spice/run_refs.SOLVER and run `python spice6as6/run_refs.py --write-netlist`.
* spice6as6/tests/test_netlists_6as6.py checks.
* One 6AS6 stage, P2 wiring (g3 to ground: our hypothesis, #111), unbypassed cathode resistor. Passive values: dk6as6/circuit.VALUES,
* inferred in issue #102 (no public schematic; sources and labels in dk6as6/RESULTS.md). Rk = the resistor the DK
* stage solves for a 0.45 mA cathode current (dk6as6.stage.cathode_resistor). Screen: an ideal source at the
* GE / Raytheon typical Ec2 = 120 V.
* Valve: fit6as6 dual_control (issue #55) behavioural subckt with the DK model's params (models/6as6_dual_cg3k.inc).
* Solver: reltol=1e-06, abstol=1e-14, vntol=1e-09, chgtol=1e-16, method=trap, tstep=5e-07, tmax=5e-07.
* .spiceinit sets ngbehavior=psa.
.include models/6as6_dual_cg3k.inc
VHT ht 0 DC 200
VG2 g2 0 DC 120
Vin src 0 DC 0 AC 1 SIN(0 0.05 1000)
Rs  src in1 1k
Cin in1 gl 100n
Rg  gl 0 1Meg
Rgs gl g 68k
XV1 a g2 0 g k 6AS6_DUAL_CG3K
Ra  ht a 270k
Rk  k 0 9830.7661553504149
Cout a out 100n
Rl  out 0 1Meg
.options reltol=1e-06 abstol=1e-14 vntol=1e-09 chgtol=1e-16 method=trap

.control
op
let ia = -i(VHT)
let ig2 = -i(VG2)
wrdata out/dual_p2_0.45ma_op.txt v(a) v(k) v(g) v(gl) ia ig2
ac dec 50 1 100k
wrdata out/dual_p2_0.45ma_ac.txt db(v(out)) ph(v(out))
ac lin 1 20 20
wrdata out/dual_p2_0.45ma_ac_20.txt db(v(out)) ph(v(out))
ac lin 1 20k 20k
wrdata out/dual_p2_0.45ma_ac_20000.txt db(v(out)) ph(v(out))
foreach A 0.05 0.5 2 8
  alter @Vin[sin] = [ 0 $A 1000 ]
  tran 5e-07 0.5 0.3 5e-07
  set fn = out/dual_p2_0.45ma_sine_{$A}.txt
  wrdata $fn v(out) v(g) v(k)
end
.endc
.end
