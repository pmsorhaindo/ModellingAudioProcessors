* GENERATED by spice6as6/run_refs.py (dual, main) -- do not edit; change dk6as6/circuit.VALUES or
* spice/run_refs.SOLVER and run `python spice6as6/run_refs.py --write-netlist`. spice6as6/tests/test_netlists_6as6.py checks.
* One-stage 6AS6 common-cathode stage. Passive values: dk6as6/circuit.VALUES = dk/circuit.VALUES (example values, NOT
* Culture Vulture values; sources in dk/circuit.py). Screen and suppressor: ideal sources at the GE / Raytheon typical
* conditions Ec2 = 120 V, Ec3 = 0 V (dk6as6/circuit.py).
* Valve: fit6as6 dual_control (issue #55) behavioural subckt with the DK model's params (models/6as6_dual.inc).
* Solver: reltol=1e-06, abstol=1e-14, vntol=1e-09, chgtol=1e-16, method=trap, tstep=5e-07, tmax=5e-07.
* .spiceinit sets ngbehavior=psa.
.include models/6as6_dual.inc
VHT ht 0 DC 300
VG2 g2 0 DC 120
VG3 g3 0 DC 0
Vin src 0 DC 0 AC 1 SIN(0 0.05 1000)
Rs  src in1 1k
Cin in1 gl 22n
Rg  gl 0 1Meg
Rgs gl g 68k
XV1 a g2 g3 g k 6AS6_DUAL
Ra  ht a 100k
Rk  k 0 1.5k
Ck  k 0 22u
Cout a out 22n
Rl  out 0 1Meg
.options reltol=1e-06 abstol=1e-14 vntol=1e-09 chgtol=1e-16 method=trap

.control
op
let ia = -i(VHT)
let ig2 = -i(VG2)
wrdata out/dual_op.txt v(a) v(k) v(g) v(gl) ia ig2
ac dec 50 1 100k
wrdata out/dual_ac.txt db(v(out)) ph(v(out))
ac lin 1 20 20
wrdata out/dual_ac_20.txt db(v(out)) ph(v(out))
ac lin 1 20k 20k
wrdata out/dual_ac_20000.txt db(v(out)) ph(v(out))
foreach A 0.05 0.5 2 8
  alter @Vin[sin] = [ 0 $A 1000 ]
  tran 5e-07 0.5 0.3 5e-07
  set fn = out/dual_sine_{$A}.txt
  wrdata $fn v(out) v(g) v(k)
end
.endc
.end
